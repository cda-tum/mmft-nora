* resistive network as exported from excel.
* Important! node 0 has been replaced with node 55 as 0 is default GND
R1 4 5 8.05e11
R2 5 55 1.58e11
R3 6 1 9.10e09
R4 55 3 1.17e10
R5 1 2 2.02e10
R6 2 7 1.38e10
R7 7 8 4.14e10
R8 3 8 3.21e10
R9 8 9 3.48e10
R10 10 4 2.44e11
R11 11 4 1.77e11
R12 9 15 3.57e10
R13 15 29 1.86e11
R14 20 21 8.05e11
R15 21 16 4.32e10
R16 22 17 2.13e11
R17 16 19 1.17e10
R18 17 18 2.02e10
R19 18 23 3.35e10
R20 23 24 1.01e11
R21 19 24 7.79e10
R22 24 25 8.40e10
R23 26 20 9.02e10
R24 27 20 3.66e10
R25 25 29 8.61e10
R26 29 43 2.84e11
R27 34 35 8.05e11
R28 35 30 5.53e10
R29 36 31 1.09e12
R30 30 33 1.17e10
R31 31 32 2.02e10
R32 32 37 8.30e10
R33 37 38 2.49e11
R34 33 38 1.93e11
R35 38 39 2.26e11
R36 40 34 3.96e10
R37 41 34 1.34e11
R38 39 43 2.32e11
R39 43 54 2.82e11
R40 53 14 4.14e11
R41 14 36 2.75e11
R42 27 41 5.35e11
R43 36 22 1.54e11
R44 11 27 2.76e11
R45 22 6 4.75e10
R46 13 11 1.92e11
R47 42 40 7.95e10
R48 28 26 1.81e11
R49 12 10 4.90e11
R50 47 48 7.27e10
R51 48 42 7.12e11
R52 28 47 9.97e08
R53 49 47 8.34e10
R54 46 49 8.49e11
R55 44 45 4.34e10
R56 45 28 7.12e11
R57 12 44 3.97e11
R58 46 44 8.90e09
R59 50 46 1.05e11
R60 51 12 1.48e11
R61 52 13 4.82e10

* inlets to ground
R62 0 50 0.7082
R63 0 51 0.7082
R64 0 52 0.7082
R65 0 53 0.7082

* output current source
* outflow: 7,92E-11
I1 54 0 DC 7.92e-11

.op
.end
